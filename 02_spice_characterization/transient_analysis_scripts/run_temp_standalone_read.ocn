simulator('spectre)
temp(27)

fp = outfile("/home/vlsi-lab/Ganesh_Mtech/Mtech_project_ganesh/meas_standalone_read_temp.txt" "w")

; ==============================================================================
; REUSABLE READ MEASUREMENT PROCEDURE (For Read-1 and Read-0)
; ==============================================================================
procedure(measure_read(tag expected_q_high vdd_val fp)
    let((q_w qb_w wl_w q_clip qb_clip q_start qb_start t_wl50 q_end qb_end
         q_disturb qb_disturb q_drop t_q_peak t_qb_peak read_succ
         dt_q_ps dt_qb_ps i_vdd_r i_clip i_read_int i_read_avg_ua i_read_peak_ua
         p_read_uw e_read_fj q_min_val qb_max_val q_max_val qb_min_val)

        selectResult('tran)
        q_w = v("/q")
        qb_w = v("/qb")
        wl_w = v("/w")

        ; Fail-proof terminal current detection for V0 or V3 supply source
        i_vdd_r = i("/V0/PLUS")
        if(i_vdd_r == nil then i_vdd_r = i("V0:p"))
        if(i_vdd_r == nil then i_vdd_r = i("/V0"))
        if(i_vdd_r == nil then i_vdd_r = i("V0"))
        if(i_vdd_r == nil then i_vdd_r = i("/V3/PLUS"))
        if(i_vdd_r == nil then i_vdd_r = i("V3:p"))
        if(i_vdd_r == nil then i_vdd_r = i("/V3"))
        if(i_vdd_r == nil then i_vdd_r = i("V3"))
        if(i_vdd_r != nil then i_vdd_r = -i_vdd_r)

        if(q_w != nil && qb_w != nil then
            q_clip = clip(q_w 0 10n)
            qb_clip = clip(qb_w 0 10n)

            q_start = value(q_w 0)
            if(q_start == nil then q_start = value(q_clip 0))
            qb_start = value(qb_w 0)
            if(qb_start == nil then qb_start = value(qb_clip 0))

            t_wl50 = cross(wl_w 0.5*vdd_val 1 "rising")
            if(t_wl50 == nil then t_wl50 = 0.05n)

            q_end = value(q_clip 9.99n)
            qb_end = value(qb_clip 9.99n)

            if(expected_q_high == 1 then
                ; READ-1 Analysis (Stored state Q=VDD, QB=0)
                q_min_val = ymin(q_clip)
                q_drop = (vdd_val - q_min_val) * 1000.0
                q_disturb = q_drop

                qb_max_val = ymax(qb_clip)
                qb_disturb = (qb_max_val - qb_start) * 1000.0

                t_q_peak = xmin(q_clip)
                if(t_q_peak == nil then t_q_peak = t_wl50)

                t_qb_peak = xmax(qb_clip)
                if(t_qb_peak == nil then t_qb_peak = t_wl50)

                read_succ = 1
                if(q_end < 0.5 * vdd_val || qb_end > 0.5 * vdd_val then read_succ = 0)
            else
                ; READ-0 Analysis (Stored state Q=0, QB=VDD)
                q_max_val = ymax(q_clip)
                q_disturb = (q_max_val - q_start) * 1000.0
                if(q_disturb < 0 then q_disturb = 0.0)

                qb_min_val = ymin(qb_clip)
                q_drop = (qb_start - qb_min_val) * 1000.0
                if(q_drop < 0 then q_drop = 0.0)
                qb_disturb = q_drop

                t_q_peak = xmax(q_clip)
                if(t_q_peak == nil then t_q_peak = t_wl50)

                t_qb_peak = xmin(qb_clip)
                if(t_qb_peak == nil then t_qb_peak = t_wl50)

                read_succ = 1
                if(q_end > 0.5 * vdd_val || qb_end < 0.5 * vdd_val then read_succ = 0)
            )

            dt_q_ps = (t_q_peak - t_wl50) * 1e12
            if(dt_q_ps < 0 then dt_q_ps = 0.0)

            dt_qb_ps = (t_qb_peak - t_wl50) * 1e12
            if(dt_qb_ps < 0 then dt_qb_ps = 0.0)

            i_read_avg_ua = 0.0
            i_read_peak_ua = 0.0
            p_read_uw = 0.0
            e_read_fj = 0.0

            if(i_vdd_r != nil then
                i_clip = clip(i_vdd_r 0 10n)
                i_read_int = integ(i_clip 0 10n)
                i_read_avg_ua = (i_read_int / 10e-9) * 1e6
                i_read_peak_ua = ymax(i_clip) * 1e6
                p_read_uw = vdd_val * i_read_avg_ua
                e_read_fj = vdd_val * i_read_int * 1e15
            )

            fprintf(fp "%s: max_q_disturb_mv=%g max_qb_disturb_mv=%g q_drop_mv=%g wl_to_q_disturb_peak_ps=%g wl_to_qb_disturb_peak_ps=%g average_read_current_ua=%g peak_read_current_ua=%g read_power_uw=%g read_energy_fj=%g read_success=%d\n"
                tag q_disturb qb_disturb q_drop dt_q_ps dt_qb_ps i_read_avg_ua i_read_peak_ua p_read_uw e_read_fj read_succ)
        )
    )
)

; ==============================================================================
; 1. READ TRANSIENT ANALYSIS (Sequential Read-1 and Read-0 Execution)
; ==============================================================================
design("/home/vlsi-lab/simulation/6tsram_r_trans_tb/spectre/schematic/netlist/netlist")
resultsDir("/home/vlsi-lab/simulation/6tsram_r_trans_tb/spectre/schematic")
desVar("nfin_pu" 1)
desVar("nfin_pd" 1)
desVar("nfin_acc" 1)
desVar("vdd_val" 0.6)

analysis('tran ?stop 20n ?errpreset 'moderate)

; --- A. READ-1 SIMULATION (Initial condition: Q=VDD, QB=0) ---
ic("/q" 0.6 "/qb" 0.0)
sok_r1 = errset(run())
if(sok_r1 then
    measure_read("READ_1" 1 0.6 fp)
else
    fprintf(fp "READ_1_ERROR: Spectre run failed for Read-1 testbench\n")
)

; --- B. READ-0 SIMULATION (Initial condition: Q=0, QB=VDD) ---
ic("/q" 0.0 "/qb" 0.6)
sok_r0 = errset(run())
if(sok_r0 then
    measure_read("READ_0" 0 0.6 fp)
else
    fprintf(fp "READ_0_ERROR: Spectre run failed for Read-0 testbench\n")
)

close(fp)
exit()
