; ================================================================
;  6T SRAM - READ TRANSIENT CHARACTERIZATION
;  Sweeps: nfin_pu, nfin_pd, nfin_acc, VDD, Temperature
;  Output: sram_read_dataset.csv
;
;  APPROACH: Hardcoded numeric netlist editing per iteration.
;            No desVar, no parameters line - avoids all SFE errors.
; ================================================================

; ============================================================
; CONFIGURATION - Modify these to match your testbench
; ============================================================
wl_net   = "/w"         ; Wordline net
bl_net   = "/bl"        ; Bitline net
blb_net  = "/blb"       ; Bitline-bar net
q_net    = "/q"         ; Storage node Q
qb_net   = "/qb"        ; Storage node QB
vdd_src  = "/V3"        ; VDD voltage source instance (DC supply)

; Testbench netlist path
tb_path  = simplifyFilename("~/simulation/6tsram_r_trans_tb/spectre/schematic/netlist/netlist")

; Model file path
model_path = "/home/install/FOUNDRY/cds_ff_mpt_v_0.5/cds_ff_mpt/../models/spectre/cds_ff_mpt.scs"

; Simulation time
sim_stop = "20n"

; Output file
csv_file = "./sram_read_dataset.csv"

; Results directory
res_dir  = simplifyFilename("~/simulation/6tsram_r_trans_tb/spectre/schematic")
; ============================================================

printf("\n========================================================\n")
printf("  6T SRAM READ TRANSIENT SWEEP - Starting...\n")
printf("========================================================\n\n")

; --- STEP 0: Force-delete corrupted backup ---
nf = tb_path
nf_bak = strcat(nf ".bak")
sh(sprintf(nil "rm -f %s" nf_bak))
printf("Old backup deleted.\n")

; --- STEP 1: Clean current netlist of ALL corruption from previous runs ---
sh(sprintf(nil "sed -i '/^parameters /d' %s" nf))
sh(sprintf(nil "sed -i 's/vdd_val_val/900.0m/g' %s" nf))
sh(sprintf(nil "sed -i 's/vdd_val/900.0m/g' %s" nf))
sh(sprintf(nil "sed -i 's/nfin_pd/2/g' %s" nf))
sh(sprintf(nil "sed -i 's/nfin_acc/1/g' %s" nf))
sh(sprintf(nil "sed -i 's/nfin_pu/1/g' %s" nf))
printf("Netlist cleaned of all corruption.\n")

; --- STEP 2: Create fresh backup from now-clean netlist ---
sh(sprintf(nil "cp %s %s" nf nf_bak))
printf("Fresh backup created.\n")

; --- STEP 3: Clear any cached desVar from previous OCEAN sessions ---
errset(desVar("nfin_pd" nil))
errset(desVar("nfin_acc" nil))
errset(desVar("nfin_pu" nil))
errset(desVar("vdd_val" nil))

; --- Simulator Setup ---
simulator('spectre)
design(nf)
resultsDir(res_dir)
modelFile(list(list(model_path "tt")))
option('redefinedparams "ignore")
analysis('tran ?stop sim_stop ?errpreset "moderate")
envOption('analysisOrder list("tran"))

; --- Sweep Ranges ---
puL   = '(1 2 3 4 5)
pdL   = '(1 2 3 4 5 6)
accL  = '(1 2 3 4 5)
vddL  = '(0.6 0.7 0.8 0.9)
tempL = '(27)

; --- CSV Header ---
ofile = outfile(csv_file "w")
fprintf(ofile "nfin_pu,nfin_pd,nfin_acc,vdd,temp,")
fprintf(ofile "read_delay_ps,max_q_drop_mv,max_qb_rise_mv,")
fprintf(ofile "bl_diff_mv,peak_isupply_ua,avg_isupply_ua,")
fprintf(ofile "read_power_uw,read_energy_fj,settling_time_ps,read_success\n")

; --- Count total runs ---
total = length(puL) * length(pdL) * length(accL) * length(vddL) * length(tempL)
cnt = 0

; ============================================================
;  MAIN SWEEP LOOP
; ============================================================
foreach(pu puL
  foreach(pd pdL
    foreach(acc accL
      foreach(vdd vddL
        foreach(tmp tempL

          cnt = cnt + 1
          printf("=== READ Run %d/%d: PU=%d PD=%d ACC=%d VDD=%.2f T=%d ===\n" cnt total pu pd acc vdd tmp)

          ; ---- Step 1: Restore clean netlist from backup ----
          sh(sprintf(nil "cp %s %s" nf_bak nf))

          ; ---- Step 2: Write actual numeric values into netlist ----
          ; Pull-Down NMOS (NM0, NM1)
          sh(sprintf(nil "sed -i 's/\\(NM0.*nfin=\\)[0-9][0-9]*/\\1%d/' %s" pd nf))
          sh(sprintf(nil "sed -i 's/\\(NM1.*nfin=\\)[0-9][0-9]*/\\1%d/' %s" pd nf))
          ; Access NMOS (NM2, NM3)
          sh(sprintf(nil "sed -i 's/\\(NM2.*nfin=\\)[0-9][0-9]*/\\1%d/' %s" acc nf))
          sh(sprintf(nil "sed -i 's/\\(NM3.*nfin=\\)[0-9][0-9]*/\\1%d/' %s" acc nf))
          ; Pull-Up PMOS (PM0, PM1)
          sh(sprintf(nil "sed -i 's/\\(PM0.*nfin=\\)[0-9][0-9]*/\\1%d/' %s" pu nf))
          sh(sprintf(nil "sed -i 's/\\(PM1.*nfin=\\)[0-9][0-9]*/\\1%d/' %s" pu nf))
          ; VDD supply (dc sources and pulse amplitude)
          sh(sprintf(nil "sed -i 's/dc=900\\.0m/dc=%g/g' %s" vdd nf))
          sh(sprintf(nil "sed -i 's/val1=900\\.0m/val1=%g/g' %s" vdd nf))

          ; ---- Step 3: Set temperature ----
          temp(tmp)

          ; ---- Initialize all outputs to failure defaults ----
          rd = -1.0
          q_drop = -1.0
          qb_rise = -1.0
          bl_diff = -1.0
          i_peak = -1.0
          i_avg = -1.0
          r_pwr = -1.0
          r_nrg = -1.0
          t_settle = -1.0
          r_ok = 0

          ; ---- Step 4: Run simulation ----
          sok = errset(run())
          if(sok then

            ; Explicitly open PSF results directory
            psf_path = strcat(res_dir "/psf")
            errset(openResults(psf_path))
            rok = errset(selectResult('tran))

            ; Debug diagnostics on first run
            if(cnt == 1 then
              printf("  DEBUG: PSF path = %s\n" psf_path)
              printf("  DEBUG: selectResult = %L\n" rok)
              test1 = errset(VT("/w"))
              printf("  DEBUG: VT(\"/w\") = %L\n" test1)
              test2 = errset(VT("w"))
              printf("  DEBUG: VT(\"w\")  = %L\n" test2)
              test3 = errset(VT("/net:w"))
              printf("  DEBUG: VT(\"/net:w\") = %L\n" test3)
            )

            if(rok then

              ; --- Find WL edges ---
              twl_rise = nil
              twl_fall = nil
              errset(twl_rise = cross(VT(wl_net) vdd/2.0 1 "rising"))
              errset(twl_fall = cross(VT(wl_net) vdd/2.0 1 "falling"))

              ; Fallback to pulse timing if cross() cannot find edges
              if(twl_rise == nil then twl_rise = 100e-12)
              if(twl_fall == nil then twl_fall = 10.1e-9)

              ; ---- Read Delay ----
              errset(progn(
                bl_wave = VT(bl_net) - VT(blb_net)
                trd = cross(abs(bl_wave) 0.050 1 "rising" twl_rise twl_fall)
                if(trd != nil then rd = (trd - twl_rise) * 1e12)
              ))

              ; ---- Max Q Drop (Read Disturb) ----
              errset(progn(
                q_init = value(VT(q_net) twl_rise)
                q_clip = clip(VT(q_net) twl_rise twl_fall)
                q_min  = ymin(q_clip)
                q_drop = (q_init - q_min) * 1000.0
              ))

              ; ---- Max QB Rise ----
              errset(progn(
                qb_clip = clip(VT(qb_net) twl_rise twl_fall)
                qb_max  = ymax(qb_clip)
                qb_rise = qb_max * 1000.0
              ))

              ; ---- Bitline Differential at WL falling edge ----
              errset(progn(
                bl_end  = value(VT(bl_net)  twl_fall)
                blb_end = value(VT(blb_net) twl_fall)
                bl_diff = abs(bl_end - blb_end) * 1000.0
              ))

              ; ---- Supply Current (during WL active window) ----
              errset(progn(
                isup   = abs(IT(vdd_src))
                isup_c = clip(isup twl_rise twl_fall)
                i_peak = ymax(isup_c) * 1e6
                i_avg  = average(isup_c) * 1e6
              ))

              ; ---- Read Power & Energy ----
              errset(progn(
                r_pwr = i_avg * vdd
                pwr_wave = abs(IT(vdd_src)) * vdd
                r_nrg = integ(clip(pwr_wave twl_rise twl_fall)) * 1e15
              ))

              ; ---- Settling Time ----
              errset(progn(
                q_target = q_init * 0.90
                t_back = cross(VT(q_net) q_target 1 "rising" twl_fall nil)
                if(t_back != nil then
                  t_settle = (t_back - twl_fall) * 1e12
                )
              ))

              ; ---- Read Success ----
              errset(progn(
                q_final  = value(VT(q_net) twl_fall)
                qb_final = value(VT(qb_net) twl_fall)
                if(q_final > vdd*0.6 && qb_final < vdd*0.4 then
                  r_ok = 1
                )
              ))

            else
              printf("  WARNING: No tran results.\n")
            ) ; end if rok
          else
            printf("  WARNING: Simulation failed.\n")
          ) ; end if sok

          ; --- Write CSV Row ---
          fprintf(ofile "%d,%d,%d,%.2f,%d," pu pd acc vdd tmp)
          fprintf(ofile "%.4f,%.4f,%.4f," rd q_drop qb_rise)
          fprintf(ofile "%.4f,%.4f,%.4f," bl_diff i_peak i_avg)
          fprintf(ofile "%.4f,%.4f,%.4f,%d\n" r_pwr r_nrg t_settle r_ok)

          printf("  RdDly=%.1fps Qdrop=%.1fmV QBrise=%.1fmV BLdiff=%.1fmV OK=%d\n" rd q_drop qb_rise bl_diff r_ok)

        ) ; temp
      ) ; vdd
    ) ; acc
  ) ; pd
) ; pu

close(ofile)
printf("\n========================================================\n")
printf("  READ SWEEP COMPLETE! Total runs: %d\n" cnt)
printf("  Output: %s\n" csv_file)
printf("========================================================\n")
