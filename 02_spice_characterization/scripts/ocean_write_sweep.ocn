; ================================================================
;  6T SRAM - WRITE TRANSIENT CHARACTERIZATION
;  Sweeps: nfin_pu, nfin_pd, nfin_acc, VDD, Temperature
;  Output: sram_write_dataset.csv
; ================================================================
;
;  TESTBENCH REQUIREMENTS:
;    - WL: Pulse source (0 -> VDD), rises at ~1ns, width ~5ns
;    - BL:  Forced to 0V (writing '0' into Q)
;    - BLB: Held at VDD
;    - Initial conditions: Q = VDD (storing '1'), QB = 0
;    - After write: Q should flip to 0, QB should flip to VDD
;
; ================================================================

; ============================================================
; CONFIGURATION - Modify these to match your testbench
; ============================================================
wl_net   = "/wl"        ; Wordline net
bl_net   = "/bl"        ; Bitline net
blb_net  = "/blb"       ; Bitline-bar net
q_net    = "/q"         ; Storage node Q
qb_net   = "/qb"        ; Storage node QB
vdd_src  = "/V0"        ; VDD voltage source instance name

; Testbench netlist path
tb_path  = "/home/vlsi-lab/simulation/6tsram_write_tb/spectre/schematic/netlist/netlist"

; Model file path
model_path = "/home/install/FOUNDRY/cds_ff_mpt_v_0.5/cds_ff_mpt/../models/spectre/cds_ff_mpt.scs"

; Simulation time
sim_stop = "20n"

; Output file
csv_file = "./sram_write_dataset.csv"
; ============================================================

printf("\n========================================================\n")
printf("  6T SRAM WRITE TRANSIENT SWEEP - Starting...\n")
printf("========================================================\n\n")

; --- Netlist Backup/Restore ---
nf = tb_path
nf_bak = strcat(nf ".bak")
sh(sprintf(nil "if [ ! -f %s ]; then cp %s %s; echo 'WRITE: Backup created'; else cp %s %s; echo 'WRITE: Restored from backup'; fi" nf_bak nf nf_bak nf_bak nf))

; --- Parameterize Netlist ---
sh(sprintf(nil "sed -i 's/\\(NM0.*nfin=\\)[0-9][0-9]*/\\1nfin_pd/' %s" nf))
sh(sprintf(nil "sed -i 's/\\(NM1.*nfin=\\)[0-9][0-9]*/\\1nfin_pd/' %s" nf))
sh(sprintf(nil "sed -i 's/\\(NM2.*nfin=\\)[0-9][0-9]*/\\1nfin_acc/' %s" nf))
sh(sprintf(nil "sed -i 's/\\(NM3.*nfin=\\)[0-9][0-9]*/\\1nfin_acc/' %s" nf))
sh(sprintf(nil "sed -i 's/\\(PM0.*nfin=\\)[0-9][0-9]*/\\1nfin_pu/' %s" nf))
sh(sprintf(nil "sed -i 's/\\(PM1.*nfin=\\)[0-9][0-9]*/\\1nfin_pu/' %s" nf))
sh(sprintf(nil "sed -i '/vsource/s/dc=[0-9.]*[^ ]*/dc=vdd_val/' %s" nf))

printf("Netlist parameterized.\n")

; --- Simulator Setup ---
simulator('spectre)
design(nf)
resultsDir(strcat(nf "/../.."))
modelFile(list(list(model_path "tt")))
analysis('tran ?stop sim_stop ?errpreset "moderate")
envOption('analysisOrder list("tran"))

; --- Sweep Ranges ---
puL   = '(1 2 3 4 5)
pdL   = '(1 2 3 4 5 6)
accL  = '(1 2 3 4 5)
vddL  = '(0.6 0.7 0.8 0.9)
tempL = '(27)

; --- CSV Header ---
ofile = outfile(csv_file "w")
fprintf(ofile "nfin_pu,nfin_pd,nfin_acc,vdd,temp,")
fprintf(ofile "write_delay_ps,q_fall_time_ps,qb_rise_time_ps,")
fprintf(ofile "write_power_uw,write_energy_fj,")
fprintf(ofile "peak_isupply_ua,avg_isupply_ua,")
fprintf(ofile "write_success,final_q_v,final_qb_v\n")

; --- Count total runs ---
total = length(puL) * length(pdL) * length(accL) * length(vddL) * length(tempL)
cnt = 0

; ============================================================
;  MAIN SWEEP LOOP
; ============================================================
foreach(pu puL
  foreach(pd pdL
    foreach(acc accL
      foreach(vdd vddL
        foreach(tmp tempL

          cnt = cnt + 1
          printf("=== WRITE Run %d/%d: PU=%d PD=%d ACC=%d VDD=%.2f T=%d ===\n" cnt total pu pd acc vdd tmp)

          desVar("nfin_pu"  pu)
          desVar("nfin_pd"  pd)
          desVar("nfin_acc" acc)
          desVar("vdd_val"  vdd)
          temp(tmp)

          ; Initialize all outputs to failure
          wd = -1.0  q_ft = -1.0  qb_rt = -1.0
          w_pwr = -1.0  w_nrg = -1.0
          i_peak = -1.0  i_avg = -1.0
          w_ok = 0  fin_q = -1.0  fin_qb = -1.0

          sok = errset(run())
          if(sok then
            rok = errset(selectResult('tran))
            if(rok then

              ; --- Find WL edges ---
              twl_rise = nil
              twl_fall = nil
              errset(twl_rise = cross(VT(wl_net) vdd/2.0 1 "rising"  nil nil))
              errset(twl_fall = cross(VT(wl_net) vdd/2.0 1 "falling" nil nil))

              if(twl_rise != nil && twl_fall != nil then

                ; ---- Write Delay ----
                ; Time from WL 50% rising to Q crossing VDD/2
                tq_cross = nil
                errset(tq_cross = cross(VT(q_net) vdd/2.0 1 "falling" twl_rise nil))
                if(tq_cross != nil then
                  wd = (tq_cross - twl_rise) * 1e12
                )

                ; ---- Q Fall Time (90% to 10% of VDD) ----
                errset(
                  tq_90 = cross(VT(q_net) vdd*0.9 1 "falling" twl_rise nil)
                  tq_10 = cross(VT(q_net) vdd*0.1 1 "falling" twl_rise nil)
                  if(tq_90 != nil && tq_10 != nil then
                    q_ft = (tq_10 - tq_90) * 1e12
                  )
                )

                ; ---- QB Rise Time (10% to 90% of VDD) ----
                errset(
                  tqb_10 = cross(VT(qb_net) vdd*0.1 1 "rising" twl_rise nil)
                  tqb_90 = cross(VT(qb_net) vdd*0.9 1 "rising" twl_rise nil)
                  if(tqb_10 != nil && tqb_90 != nil then
                    qb_rt = (tqb_90 - tqb_10) * 1e12
                  )
                )

                ; ---- Supply Current (during WL active window) ----
                errset(
                  isup   = abs(IT(vdd_src))
                  isup_c = clip(isup twl_rise twl_fall)
                  i_peak = ymax(isup_c) * 1e6
                  i_avg  = average(isup_c) * 1e6
                )

                ; ---- Write Power & Energy ----
                errset(
                  w_pwr = i_avg * vdd
                  pwr_wave = abs(IT(vdd_src)) * vdd
                  w_nrg = integ(clip(pwr_wave twl_rise twl_fall)) * 1e15
                )

                ; ---- Final Storage Node Voltages (measured after WL falls) ----
                ; Sample 1ns after WL falling edge for settling
                t_sample = twl_fall + 1e-9
                errset(
                  fin_q  = value(VT(q_net) t_sample)
                  fin_qb = value(VT(qb_net) t_sample)
                )

                ; ---- Write Success ----
                ; Writing '0' to Q: final Q < 0.1*VDD and final QB > 0.9*VDD
                errset(
                  if(fin_q >= 0.0 && fin_qb >= 0.0 then
                    if(fin_q < vdd*0.1 && fin_qb > vdd*0.9 then
                      w_ok = 1
                    )
                  )
                )

              else
                printf("  WARNING: WL edges not found.\n")
              ) ; end if twl_rise/fall

            else
              printf("  WARNING: No tran results.\n")
            ) ; end if rok
          else
            printf("  WARNING: Simulation failed.\n")
          ) ; end if sok

          ; --- Write CSV Row ---
          fprintf(ofile "%d,%d,%d,%.2f,%d," pu pd acc vdd tmp)
          fprintf(ofile "%.4f,%.4f,%.4f," wd q_ft qb_rt)
          fprintf(ofile "%.4f,%.4f," w_pwr w_nrg)
          fprintf(ofile "%.4f,%.4f," i_peak i_avg)
          fprintf(ofile "%d,%.6f,%.6f\n" w_ok fin_q fin_qb)

          printf("  WrDly=%.1fps Qfall=%.1fps QBrise=%.1fps OK=%d FinalQ=%.3f\n" wd q_ft qb_rt w_ok fin_q)

        ) ; temp
      ) ; vdd
    ) ; acc
  ) ; pd
) ; pu

close(ofile)
printf("\n========================================================\n")
printf("  WRITE SWEEP COMPLETE! Total runs: %d\n" cnt)
printf("  Output: %s\n" csv_file)
printf("========================================================\n")
